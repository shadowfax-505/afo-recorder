Revision B four-channel analog model
VDD avdd 0 3
VMID mid 0 1.5

* Substitute closed-loop MCP600x approximation: 1 MHz pole, 1 ohm output,
* 20mV assumed rail headroom. NOT a manufacturer macromodel.
* Omits noise, bias/offset, current/slew limiting, PSRR, temperature and stability.
.subckt buffer inp out
Ein sense 0 inp 0 1
Rbw sense pole 1k
Cbw pole 0 159.154943p
Blimit driver 0 V=min(max(V(pole),0.02),2.98)
Ro driver out 1
.ends

Braw0 raw0 0 V=1.5+0.4*(1+0.3*sin(2*pi*2*time))*sin(2*pi*71*time)+0.07*sin(2*pi*50*time)+0.05*sin(2*pi*6500*time)
Rb0 raw0 mid 1Meg
Ra0 raw0 a0 3300
Ca0 a0 0 4.7e-08
Xa0 a0 ba0 buffer
Rmix0 ba0 mix0 6650
Rmid0 mid mix0 6650
Cb0 mix0 0 4.7e-08
Xb0 mix0 bb0 buffer
Rp0 bb0 p0 100
Rn0 mid n0 100
Cd0 p0 n0 1n
Rload0 p0 n0 330k
Braw1 raw1 0 V=1.5+0.4*(1+0.3*sin(2*pi*2*time))*sin(2*pi*94*time)+0.07*sin(2*pi*50*time)+0.05*sin(2*pi*6500*time)
Rb1 raw1 mid 1Meg
Ra1 raw1 a1 3300
Ca1 a1 0 4.7e-08
Xa1 a1 ba1 buffer
Rmix1 ba1 mix1 6650
Rmid1 mid mix1 6650
Cb1 mix1 0 4.7e-08
Xb1 mix1 bb1 buffer
Rp1 bb1 p1 100
Rn1 mid n1 100
Cd1 p1 n1 1n
Rload1 p1 n1 330k
Braw2 raw2 0 V=1.5+0.4*(1+0.3*sin(2*pi*2*time))*sin(2*pi*117*time)+0.07*sin(2*pi*50*time)+0.05*sin(2*pi*6500*time)
Rb2 raw2 mid 1Meg
Ra2 raw2 a2 3300
Ca2 a2 0 4.7e-08
Xa2 a2 ba2 buffer
Rmix2 ba2 mix2 6650
Rmid2 mid mix2 6650
Cb2 mix2 0 4.7e-08
Xb2 mix2 bb2 buffer
Rp2 bb2 p2 100
Rn2 mid n2 100
Cd2 p2 n2 1n
Rload2 p2 n2 330k
Braw3 raw3 0 V=1.5+0.4*(1+0.3*sin(2*pi*2*time))*sin(2*pi*140*time)+0.07*sin(2*pi*50*time)+0.05*sin(2*pi*6500*time)
Rb3 raw3 mid 1Meg
Ra3 raw3 a3 3300
Ca3 a3 0 4.7e-08
Xa3 a3 ba3 buffer
Rmix3 ba3 mix3 6650
Rmid3 mid mix3 6650
Cb3 mix3 0 4.7e-08
Xb3 mix3 bb3 buffer
Rp3 bb3 p3 100
Rn3 mid n3 100
Cd3 p3 n3 1n
Rload3 p3 n3 330k
.end
